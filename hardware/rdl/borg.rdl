// SPDX-FileCopyrightText: © 2026 Andreas Wendleder
// SPDX-License-Identifier: CERN-OHL-S-2.0
//
// Borg GPU — SystemRDL 2.0 Register Description
//
// This file is the machine-parsable single source of truth for the Borg GPU
// MMIO register map.  It mirrors the constants defined in MmioMap.scala and
// is intended to replace them via PeakRDL code generation (Step 14).
//
// Address space: 1024 bytes (10-bit byte address), 32-bit data bus.
// All registers are 32-bit aligned (4-byte stride).
//
// Offset computation (matches Chisel):
//   REG_FILE:     0x000 – 0x07C  (32 × 4 = 128 bytes)
//   IMEM:         0x080 – 0x15C  (56 × 4 = 224 bytes)
//   ITER_BBOX:    0x160
//   ITER:         0x164
//   CONTROL:      0x168  (write: control, read: status — same address)
//   FRAG_PC:      0x16C
//   UNIFORM[0]:   0x170 – 0x1EC  (32 × 4 = 128 bytes, MMIO window = 1 page)
//   TILE_CTRL:    0x1F0
//   TILE_RG:      0x1F4
//   TILE_BZ:      0x1F8
//   CMD_ENQUEUE:  0x1FC

// ============================================================================
// User-defined properties
// ============================================================================

// nogen: when true on a register instance, suppresses hardware synthesis for
// that register.  The offset constant is still emitted for firmware
// compatibility; writes to the MMIO address are silently ignored by hardware.
property nogen { type = boolean; default = false; component = reg; };

// ============================================================================
// Field / Register type definitions
// ============================================================================

// --- Coordinate (10-bit x/y pair, matches Chisel Coord bundle) ---
field coord_field_t {
    sw = rw; hw = r;
    fieldwidth = 10;
};

// --- Iterator read-back ---
// Bit layout: {rsvd[31:22], inside[21], valid[20], y[19:10], x[9:0]}
reg iter_reg_t {
    name = "Pixel Iterator Position";
    desc = "Read: current iterator position plus valid/inside flags.
            Write: advance the iterator by one pixel (data ignored).";

    field {
        sw = r; hw = w;
        desc = "Current pixel X coordinate (10-bit).";
    } x[10] = 0;

    field {
        sw = r; hw = w;
        desc = "Current pixel Y coordinate (10-bit).";
    } y[10] = 0;

    field {
        sw = r; hw = w;
        desc = "Iterator valid flag — 1 while inside bounding box.";
    } valid[1] = 0;

    field {
        sw = r; hw = w;
        desc = "Inside flag — 1 if current pixel passes all 3 edge tests.";
    } inside_flag[1] = 0;

    field {
        sw = r; hw = na;
    } RSVD[10] = 0;
};

// --- Control register (write path) ---
// The control and status registers share the same address (0x168).
// A write drives the control fields; a read returns the status fields.
reg control_reg_t {
    name = "GPU Control";
    desc = "Write: start execution, reset pipeline, set uniform write page and
            start PC.  Bits are active-high, self-clearing where noted.";

    field {
        sw = w; hw = r;
        singlepulse;
        desc = "Bit 0: Start shader execution (self-clearing pulse).";
    } start[1] = 0;

    field {
        sw = w; hw = r;
        singlepulse;
        desc = "Bit 1: Reset the pipeline (self-clearing pulse).";
    } reset_pipeline[1] = 0;

    field {
        sw = w; hw = na;
        desc = "Bits 4:2: Reserved.";
    } RSVD_ctl[3] = 0;

    field {
        sw = w; hw = r;
        desc = "Bit 5: Select which uniform buffer page (0 or 1) MMIO writes
                target.  The GPU reads from the page specified per-command by
                the Command FIFO entry's uniformPage field.";
    } uniform_write_page[1] = 0;

    field {
        sw = w; hw = r;
        desc = "Bits 12:6: Shader start PC (7-bit program counter offset into
                IMEM).  Widened 6->7 bits for IMEM=72 (the scalar-FPU helper
                program lives at IMEM[70], past the 56-word borgc fragment); a
                6-bit field truncated PC>=64 to PC&0x3F, silently mis-starting
                borg_fp16_mul/add/fmadd/rcp and zeroing all CPU-side fp16 math.";
    } start_pc[7] = 0;

    field {
        sw = w; hw = na;
    } RSVD_hi[19] = 0;
};

// --- Status register (read path at same address as CONTROL) ---
reg status_reg_t {
    name = "GPU Status";
    desc = "Read-only status at the same address as CONTROL (0x168).
            Hardware returns this value on read; writes go to control_reg_t.";

    field {
        sw = r; hw = w;
        desc = "Bit 0: Reserved (always 0).";
    } RSVD0[1] = 0;

    field {
        sw = r; hw = w;
        desc = "Bit 1: Idle — 1 when the shader pipeline is not running.";
    } idle[1] = 0;

    field {
        sw = r; hw = w;
        desc = "Bit 2: FIFO full — 1 when the Command FIFO cannot accept
                another entry.  Firmware must poll this before enqueue.";
    } fifo_full[1] = 0;

    field {
        sw = r; hw = w;
        desc = "Bit 3: DMA busy — 1 while the DMA engine is transferring data
                from DRAM to IMEM or the uniform buffer.";
    } dma_busy[1] = 0;

    field {
        sw = r; hw = w;
        desc = "Bit 4: Flush busy — 1 while BorgTileFlusher is writing tile
                pixels to DRAM.  Firmware polls this bit instead of doing
                manual DRAM writes (Step 25.3h).";
    } flush_busy[1] = 0;

    field {
        sw = r; hw = w;
        desc = "Bit 5: Sequencer busy — 1 while BorgSequencer is processing a
                vertex/setup shader sequence (Step 29).  Firmware polls this
                bit after triggering SEQ_TRIGGER to know when the GPU has
                finished computing uniforms and is ready for tile commands.";
    } seq_busy[1] = 0;

    field {
        sw = r; hw = na;
    } RSVD_hi[26] = 0;
};

// --- Fragment shader start PC ---
reg frag_pc_reg_t {
    name = "Fragment Shader Start PC";
    desc = "Write the IMEM entry point for the fragment shader.  The rasterizer
            auto-chains to this PC after the rasterize shader completes for an
            inside pixel.";

    field {
        sw = rw; hw = r;
        desc = "6-bit fragment shader program counter.";
    } frag_pc[6] = 0;

    field {
        sw = rw; hw = na;
    } RSVD[26] = 0;
};

// --- DMA DRAM base address (Step 22.1) ---
reg dma_dram_reg_t {
    name = "DMA DRAM Base Address";
    desc = "DRAM byte address of the first word to transfer.  Must be
            4-byte aligned.  Write before triggering DMA_CONFIG.start.";

    field {
        sw = rw; hw = r;
        desc = "Bits 19:0: 20-bit DRAM byte address.";
    } base[20] = 0;

    field {
        sw = rw; hw = na;
    } RSVD[12] = 0;
};

// --- DMA transfer config + trigger (Step 22.1) ---
reg dma_config_reg_t {
    name = "DMA Configuration";
    desc = "Configures and triggers a bulk DMA transfer from DRAM into
            IMEM or the uniform buffer.  Write DMA_ADDR first, then write
            this register with start=1 to launch the transfer.  Poll
            STATUS.dma_busy (bit 3) for completion.";

    field {
        sw = w; hw = r;
        singlepulse;
        desc = "Bit 0: Start DMA transfer (self-clearing pulse).";
    } start[1] = 0;

    field {
        sw = rw; hw = r;
        desc = "Bits 6:1: Number of 32-bit words to transfer (1–56 for IMEM,
                1–32 for uniforms).";
    } length[6] = 0;

    field {
        sw = rw; hw = r;
        desc = "Bits 8:7: Destination buffer.
                0=IMEM, 1=Uniform-page0, 2=Uniform-page1.";
    } dest[2] = 0;

    field {
        sw = rw; hw = r;
        desc = "Bits 14:9: Starting word index in the destination buffer.";
    } offset[6] = 0;

    field {
        sw = rw; hw = na;
    } RSVD[17] = 0;
};

// --- Tile buffer CTRL ---
// Write: bits[3:0] = pixel index (triggers BRAM read), bit[4] = clear.
reg tile_ctrl_reg_t {
    name = "Tile Buffer Control";
    desc = "Write to set the tile buffer read index or trigger a clear.
            Setting bit 4 clears the entire 4×4 tile buffer.";

    field {
        sw = w; hw = r;
        desc = "Bits 3:0: Tile buffer pixel index (0–15) for read-back.
                Writing this triggers a BRAM read; data is available at
                TILE_RG / TILE_BZ on the next cycle.";
    } read_idx[4] = 0;

    field {
        sw = w; hw = r;
        singlepulse;
        desc = "Bit 4: Clear — writing 1 clears all 16 tile entries.";
    } clear[1] = 0;

    field {
        sw = w; hw = na;
    } RSVD[27] = 0;
};

// --- Tile buffer RG read-back ---
// Read: {R[31:16], G[15:0]} of the indexed pixel.
// Write: triggers a tile buffer write (with values from BZ shadow + this RG).
reg tile_rg_reg_t {
    name = "Tile Buffer RG";
    desc = "Read: packed {R[31:16], G[15:0]} of the tile pixel selected by
            TILE_CTRL.read_idx.
            Write: combined with BZ shadow registers to write a full RGBZ pixel.";

    field {
        sw = rw; hw = r;
        desc = "Green channel (FP16, bits 15:0).";
    } g[16] = 0;

    field {
        sw = rw; hw = r;
        desc = "Red channel (FP16, bits 31:16).";
    } red[16] = 0;
};

// --- Tile buffer BZ read-back / shadow ---
// Read: {B[31:16], Z[15:0]} of the indexed pixel.
// Write: latches B and Z into shadow registers for the next RG write trigger.
reg tile_bz_reg_t {
    name = "Tile Buffer BZ";
    desc = "Read: packed {B[31:16], Z[15:0]} of the tile pixel selected by
            TILE_CTRL.read_idx.
            Write: latches B and Z into shadow registers; the actual tile buffer
            write is triggered by the subsequent TILE_RG write.";

    field {
        sw = rw; hw = r;
        desc = "Depth channel (FP16, bits 15:0).";
    } z[16] = 0;

    field {
        sw = rw; hw = r;
        desc = "Blue channel (FP16, bits 31:16).";
    } b[16] = 0;
};

// --- Command FIFO enqueue ---
// Write: {rsvd[31:20], tile_y[19:10], tile_x[9:0]}
// frag_pc and uniform_page are read from their dedicated registers.
reg cmd_enqueue_reg_t {
    name = "Command FIFO Enqueue";
    desc = "Write-only.  Push a rasterization command into the 2-entry Command
            FIFO.  The command specifies the 4×4 tile origin (in pixel coords).
            frag_pc comes from FRAG_PC register; uniform page from CONTROL.
            Poll STATUS.fifo_full before writing.";

    field {
        sw = w; hw = r;
        desc = "Bits 9:0: Tile origin X (10-bit pixel coordinate, 4-aligned).";
    } tile_x[10] = 0;

    field {
        sw = w; hw = r;
        desc = "Bits 19:10: Tile origin Y (10-bit pixel coordinate, 4-aligned).";
    } tile_y[10] = 0;

    field {
        sw = w; hw = na;
    } RSVD[12] = 0;
};

// tex_uv_reg_t removed: hardware now uses rasterizer UV snoop; firmware never writes this register.

// --- Texture configuration (Step 21.2) ---
// Write: set texture DRAM base address and enable hardware texel fetch.
reg tex_config_reg_t {
    name = "Texture Configuration";
    desc = "Configures the hardware sTexFetch path.  Write base_addr and en
            before submitting textured draw commands.  base_addr is a 16-bit
            word index (×8 for byte offset, matching the 8-byte-per-texel layout).
            Set en=1 to enable autonomous texel fetches after each fragment shade.";

    field {
        sw = rw; hw = r;
        desc = "Bits 15:0: DRAM base address of the texture (16-bit word index).";
    } base_addr[16] = 0;

    field {
        sw = rw; hw = r;
        desc = "Bit 16: Enable hardware texel fetch (sTexFetch FSM).  0=disabled.";
    } en[1] = 0;

    field {
        sw = rw; hw = r;
        desc = "Bit 17: Fragment uniform-staging mode for u19-u27.  0 = vertex
                colour R/G/B (the hand-written frag.s, outColor = texel*color);
                1 = per-vertex model position frag_pos.x/y/z (the borgc cube.frag,
                which derives the normal via dFdx/dFdy(frag_pos)).  Set by the
                firmware to match the loaded fragment shader.";
    } frag_uses_fragpos[1] = 0;

    field {
        sw = rw; hw = na;
    } RSVD[14] = 0;
};

// --- Texture address (computed by hardware) ---
// Read: Morton-encoded texel index from the most recent tex_uv write.
reg tex_addr_reg_t {
    name = "Texture Address";
    desc = "Read-only.  Returns the Morton-encoded 16-bit texel index computed
            from the most recent tex_uv write, plus raw uint8 coordinates.";

    field {
        sw = r; hw = w;
        desc = "Bits 15:0: Morton-encoded texel index.";
    } morton[16] = 0;

    field {
        sw = r; hw = w;
        desc = "Bits 23:16: Raw uint8 U coordinate.";
    } raw_u[8] = 0;

    field {
        sw = r; hw = w;
        desc = "Bits 31:24: Raw uint8 V coordinate.";
    } raw_v[8] = 0;
};

// --- Tile flusher framebuffer base address (Step 25.3h) ---
reg flush_fb_base_reg_t {
    name = "Flush Framebuffer Base Address";
    desc = "20-bit DRAM byte address of the framebuffer base.
            Written by firmware at startup; read by BorgTileFlusher on every
            tile flush.  nogen: decoded from the raw bus by Borg.scala.";

    field {
        sw = rw; hw = r;
        desc = "Bits 19:0: 20-bit DRAM byte address of framebuffer base.";
    } fb_base[20] = 0;

    field {
        sw = rw; hw = na;
    } RSVD[12] = 0;
};

// --- Tile flusher Z-buffer base address (Step 25.3h) ---
reg flush_zb_base_reg_t {
    name = "Flush Z-buffer Base Address";
    desc = "20-bit DRAM byte address of the Z-buffer base.
            Written by firmware at startup; read by BorgTileFlusher on every
            tile flush.  nogen: decoded from the raw bus by Borg.scala.";

    field {
        sw = rw; hw = r;
        desc = "Bits 19:0: 20-bit DRAM byte address of Z-buffer base.";
    } zb_base[20] = 0;

    field {
        sw = rw; hw = na;
    } RSVD[12] = 0;
};

// --- Tile flusher framebuffer width (Step 25.3h) ---
reg flush_width_reg_t {
    name = "Flush Framebuffer Width";
    desc = "9-bit framebuffer width in pixels (max 512).
            Written by firmware at startup; used by BorgTileFlusher to compute
            per-pixel DRAM addresses.  nogen: decoded from the raw bus.";

    field {
        sw = rw; hw = r;
        desc = "Bits 8:0: Framebuffer width in pixels.";
    } fb_width[9] = 0;

    field {
        sw = rw; hw = na;
    } RSVD[23] = 0;
};



// --- Vertex Sequencer: descriptor DRAM base address (Step 29) ---
reg seq_desc_base_reg_t {
    name = "Sequencer Descriptor Base Address";
    desc = "20-bit DRAM byte address of the triangle descriptor (Option A layout:
            25 FP16 words = pos[3×3] | color[3×3] | uv[3×2] | flags).
            Write before triggering SEQ_TRIGGER.  nogen: decoded in Borg.scala.";

    field {
        sw = rw; hw = r;
        desc = "Bits 19:0: 20-bit DRAM byte address of triangle descriptor.";
    } base[20] = 0;

    field {
        sw = rw; hw = na;
    } RSVD[12] = 0;
};

// --- Vertex Sequencer: trigger (Step 29) ---
reg seq_trigger_reg_t {
    name = "Sequencer Trigger";
    desc = "Write bit 0 = 1 to start the vertex/triangle-setup sequencer.
            SEQ_DESC_BASE must be set before triggering.  Self-clearing.
            Poll STATUS.seq_busy for completion.  nogen: decoded in Borg.scala.";

    field {
        sw = w; hw = r;
        singlepulse;
        desc = "Bit 0: Start sequencer (self-clearing pulse).";
    } start[1] = 0;

    field {
        sw = w; hw = na;
    } RSVD[31] = 0;
};

// --- Vertex Sequencer: vertex shader DRAM address (Step 29.1) ---
reg seq_vert_addr_reg_t {
    name = "Sequencer Vertex Shader Address";
    desc = "20-bit DRAM byte address of the vertex shader binary.
            The sequencer DMA-loads this shader into IMEM before running
            vertex transformations.  nogen: decoded in Borg.scala.";

    field {
        sw = rw; hw = r;
        desc = "Bits 19:0: 20-bit DRAM byte address of vertex shader.";
    } addr[20] = 0;

    field {
        sw = rw; hw = na;
    } RSVD[12] = 0;
};

// --- Vertex Sequencer: vertex shader length (Step 29.1) ---
reg seq_vert_len_reg_t {
    name = "Sequencer Vertex Shader Length";
    desc = "Length of vertex shader binary in 32-bit DRAM words (1–56).
            The sequencer passes this to BorgDMA as the transfer length.
            nogen: decoded in Borg.scala.";

    field {
        sw = rw; hw = r;
        desc = "Bits 5:0: vertex shader length in 32-bit words.";
    } len[6] = 0;

    field {
        sw = rw; hw = na;
    } RSVD[26] = 0;
};

// --- Vertex Sequencer: setup shader DRAM address (Step 29.2) ---
reg seq_setup_addr_reg_t {
    name = "Sequencer Setup Shader Address";
    desc = "20-bit DRAM byte address of the triangle setup shader binary.
            The sequencer DMA-loads this shader into IMEM after vertex shading
            to compute edge vectors and inv_area.  nogen: decoded in Borg.scala.";

    field {
        sw = rw; hw = r;
        desc = "Bits 19:0: 20-bit DRAM byte address of setup shader.";
    } addr[20] = 0;

    field {
        sw = rw; hw = na;
    } RSVD[12] = 0;
};

// --- Vertex Sequencer: setup shader length (Step 29.2) ---
reg seq_setup_len_reg_t {
    name = "Sequencer Setup Shader Length";
    desc = "Length of setup shader binary in 32-bit DRAM words (1–56).
            nogen: decoded in Borg.scala.";

    field {
        sw = rw; hw = r;
        desc = "Bits 5:0: setup shader length in 32-bit words.";
    } len[6] = 0;

    field {
        sw = rw; hw = na;
    } RSVD[26] = 0;
};

// --- Vertex Sequencer: inv_width for edge normalization (Step 30.1c) ---
reg seq_inv_width_reg_t {
    name = "Sequencer Inverse Width";
    desc = "FP16 value of 1/fb_width, written once during init.
            The sequencer writes this as u6 before running the setup shader,
            enabling hardware-level edge normalization.  nogen: decoded in Borg.scala.";

    field {
        sw = rw; hw = r;
        desc = "Bits 15:0: FP16 value of 1/fb_width.";
    } value[16] = 0;

    field {
        sw = rw; hw = na;
    } RSVD[16] = 0;
};

// --- Sequencer: triangle count (Step 31) ---
reg seq_tri_count_reg_t {
    name = "Sequencer Triangle Count";
    desc = "Number of triangle descriptors to process (1–16).
            The sequencer loops through triCount descriptors starting at
            SEQ_DESC_BASE with 128-byte stride.  nogen: decoded in Borg.scala.";

    field {
        sw = rw; hw = r;
        desc = "Bits 4:0: triangle count (1–16).";
    } count[5] = 0;

    field {
        sw = rw; hw = na;
    } RSVD[27] = 0;
};

// --- Sequencer: rast shader DRAM address (Step 31) ---
reg seq_rast_addr_reg_t {
    name = "Sequencer Rast Shader Address";
    desc = "20-bit DRAM byte address of the rasterizer shader binary.
            The sequencer DMA-loads this shader into IMEM after triangle setup
            to prepare for tile iteration.  nogen: decoded in Borg.scala.";

    field {
        sw = rw; hw = r;
        desc = "Bits 19:0: 20-bit DRAM byte address of rast shader.";
    } addr[20] = 0;

    field {
        sw = rw; hw = na;
    } RSVD[12] = 0;
};

// --- Sequencer: rast shader length (Step 31) ---
reg seq_rast_len_reg_t {
    name = "Sequencer Rast Shader Length";
    desc = "Length of rast shader binary in 32-bit DRAM words (1–56).
            nogen: decoded in Borg.scala.";

    field {
        sw = rw; hw = r;
        desc = "Bits 5:0: rast shader length in 32-bit words.";
    } len[6] = 0;

    field {
        sw = rw; hw = na;
    } RSVD[26] = 0;
};

// --- Sequencer: frag shader DRAM address (Step 31) ---
reg seq_frag_addr_reg_t {
    name = "Sequencer Frag Shader Address";
    desc = "20-bit DRAM byte address of the fragment shader binary.
            The sequencer DMA-loads this shader into IMEM after the rast shader
            to prepare for fragment shading.  nogen: decoded in Borg.scala.";

    field {
        sw = rw; hw = r;
        desc = "Bits 19:0: 20-bit DRAM byte address of frag shader.";
    } addr[20] = 0;

    field {
        sw = rw; hw = na;
    } RSVD[12] = 0;
};

// --- Sequencer: frag shader length (Step 31) ---
reg seq_frag_len_reg_t {
    name = "Sequencer Frag Shader Length";
    desc = "Length of frag shader binary in 32-bit DRAM words (1–56).
            nogen: decoded in Borg.scala.";

    field {
        sw = rw; hw = r;
        desc = "Bits 5:0: frag shader length in 32-bit words.";
    } len[6] = 0;

    field {
        sw = rw; hw = na;
    } RSVD[26] = 0;
};

// --- Sequencer: clear color low word (Step 31) ---
reg seq_clear_lo_reg_t {
    name = "Sequencer Clear Color Low";
    desc = "Packed {B[31:16], Z[15:0]} clear color for tile buffer pre-fill.
            The sequencer writes this to all 16 tile buffer entries before the
            first triangle on each tile.  nogen: decoded in Borg.scala.";

    field {
        sw = rw; hw = r;
        desc = "Bits 15:0: Z channel (FP16) of clear color.";
    } z[16] = 0;

    field {
        sw = rw; hw = r;
        desc = "Bits 31:16: B channel (FP16) of clear color.";
    } b[16] = 0;
};

// --- Sequencer: clear color high word (Step 31) ---
reg seq_clear_hi_reg_t {
    name = "Sequencer Clear Color High";
    desc = "Packed {R[31:16], G[15:0]} clear color for tile buffer pre-fill.
            nogen: decoded in Borg.scala.";

    field {
        sw = rw; hw = r;
        desc = "Bits 15:0: G channel (FP16) of clear color.";
    } g[16] = 0;

    field {
        sw = rw; hw = r;
        desc = "Bits 31:16: R channel (FP16) of clear color.";
    } red[16] = 0;
};

// --- Sequencer: Framebuffer base address (Step 31.4) ---
reg seq_fb_base_reg_t {
    name = "Sequencer Framebuffer Base Address";
    desc = "20-bit DRAM byte address of the framebuffer.
            Used by the sequencer to dynamically compute the flush base address
            during autonomous tile iteration.  nogen: decoded in Borg.scala.";

    field {
        sw = rw; hw = r;
        desc = "Bits 19:0: 20-bit DRAM byte address of framebuffer.";
    } addr[20] = 0;

    field {
        sw = rw; hw = na;
    } RSVD[12] = 0;
};

// --- Sequencer: Tiles per row (Step 31.4) ---
reg seq_tiles_per_row_reg_t {
    name = "Sequencer Tiles Per Row";
    desc = "Number of tiles in one row of the framebuffer (fb_width / 4).
            Used by the sequencer to compute the tile index.
            nogen: decoded in Borg.scala.";

    field {
        sw = rw; hw = r;
        desc = "Bits 9:0: tiles per row.";
    } count[10] = 0;

    field {
        sw = rw; hw = na;
    } RSVD[22] = 0;
};

// --- Sequencer: TBR bin list base address (Step 32.2) ---
reg seq_bin_base_reg_t {
    name = "Sequencer Bin List Base Address";
    desc = "20-bit DRAM byte address of the TBR bin list region.
            Each tile has a row of SEQ_MAX_TRI × 2-byte triangle indices.
            Written by firmware at frame start.  nogen: decoded in Borg.scala.";

    field {
        sw = rw; hw = r;
        desc = "Bits 19:0: 20-bit DRAM byte address of bin list base.";
    } addr[20] = 0;

    field {
        sw = rw; hw = na;
    } RSVD[12] = 0;
};

// --- Sequencer: TBR bin row bytes (Step 32.2) ---
reg seq_bin_row_bytes_reg_t {
    name = "Sequencer Bin Row Bytes";
    desc = "Bin list row size in bytes (= SEQ_MAX_TRI × TBR_BIN_ENTRY_SIZE).
            Each tile's bin list is this many bytes long in DRAM.
            Written by firmware at frame start.  nogen: decoded in Borg.scala.";

    field {
        sw = rw; hw = r;
        desc = "Bits 19:0: bin row size in bytes.";
    } size[20] = 0;

    field {
        sw = rw; hw = na;
    } RSVD[12] = 0;
};

// --- Sequencer: TBR setup store base address (Step 32.3) ---
reg seq_setup_base_reg_t {
    name = "Sequencer Setup Store Base Address";
    desc = "20-bit DRAM byte address of the TBR setup store region.
            Each triangle's 31 uniforms are stored at stride 128 bytes.
            Written by firmware at frame start.  nogen: decoded in Borg.scala.";

    field {
        sw = rw; hw = r;
        desc = "Bits 19:0: 20-bit DRAM byte address of setup store base.";
    } addr[20] = 0;

    field {
        sw = rw; hw = na;
    } RSVD[12] = 0;
};

// --- Performance counter (present-phase decomposition) ---
// 32-bit free-running cycle counter.  Counter logic lives in Borg.scala
// (wirePerf): reset at the rising edge of sequencer-busy, accumulated while its
// gate is high during the render, frozen when the sequencer goes idle — so SW
// reads the previous frame's exact cycle breakdown.  sw=r/hw=w exposes the
// Borg-side counter value to MMIO read, mirroring the status register.
reg perf_counter_reg_t {
    name = "Performance Counter";
    desc = "32-bit GPU cycle counter for present-phase decomposition.";

    field {
        sw = r; hw = w;
        desc = "32-bit cycle count (gate-dependent, per sequencer run).";
    } value[32] = 0;
};

// --- 16-bit FP register (stored in 32-bit word, upper bits ignored on write) ---
reg gpr_reg_t {
    name = "General Purpose Register";
    desc = "FP16 GPU register.  Writes use the low 16 bits of the 32-bit data
            word; reads return the 16-bit value zero-extended to 32 bits.
            32 entries: r0–r31.";

    field {
        sw = rw; hw = rw;
        desc = "FP16 register value.";
    } value[16] = 0;

    field {
        sw = r; hw = na;
    } RSVD[16] = 0;
};

// --- 32-bit instruction memory word ---
reg imem_reg_t {
    name = "Instruction Memory";
    desc = "32-bit RISC-V instruction word.  56 slots (0–55).  Write-only from
            MMIO; the FPU fetches instructions from here during execution.";

    field {
        sw = w; hw = r;
        desc = "32-bit instruction (RISC-V R-type or R4-type encoding).";
    } instruction[32] = 0;
};

// --- 16-bit uniform buffer entry ---
reg uniform_reg_t {
    name = "Uniform Buffer Entry";
    desc = "FP16 uniform value.  32 entries visible via MMIO (one page);
            CONTROL.uniform_write_page selects which hardware page (0 or 1)
            these writes target.  The GPU reads the page selected by the
            Command FIFO entry's uniformPage field.";

    field {
        sw = w; hw = r;
        desc = "FP16 uniform value (low 16 bits of 32-bit write).";
    } value[16] = 0;

    field {
        sw = w; hw = na;
    } RSVD[16] = 0;
};


// ============================================================================
// Address map
// ============================================================================

addrmap borg_gpu {
    name = "Borg GPU";
    desc = "Borg minimal FP16 shading processor — SystemRDL 2.0 register map.
            1024-byte address space (byte 0x000–0x3FF), 32-bit aligned.
            Base address is USER_BASE + USER_PERI_BORG × 1024 = 0x08000C00.";

    default hw = r;
    default sw = rw;

    // ---- Register File: 0x000 – 0x07C (32 entries × 4 bytes) ----
    gpr_reg_t gpr[32] @ 0x000 += 0x4;

    // ---- Instruction Memory: 0x080 – 0x19C (72 entries × 4 bytes) ----
    imem_reg_t imem[72] @ 0x080 += 0x4;

    // ---- Pixel Iterator Position / Advance: 0x1A4 ----
    iter_reg_t iter @ 0x1A4;

    // ---- Control (write only): 0x168 ----
    control_reg_t control;

    // ---- Status (read only): 0x16C ----
    status_reg_t status;

    // ---- Uniform Buffer (1 page × 32 entries): 0x170 – 0x1EC ----
    uniform_reg_t uniform[32] += 0x4;

    // ---- Tile Buffer Control: 0x1F0 ----
    tile_ctrl_reg_t tile_ctrl;

    // ---- Tile Buffer RG Read / Write Trigger: 0x1F4 ----
    tile_rg_reg_t tile_rg;

    // ---- Tile Buffer BZ Read / Shadow Latch: 0x1F8 ----
    tile_bz_reg_t tile_bz;

    // ---- Command FIFO Enqueue: 0x1FC ----
    cmd_enqueue_reg_t cmd_enqueue;

    // tex_uv removed (no hw ports; firmware never writes it)

    // ---- Texture Address (HW-computed): 0x204 ----
    tex_addr_reg_t tex_addr;

    // ---- Texture Configuration: 0x208 ----
    tex_config_reg_t tex_config;

    // ---- Fragment Shader Start PC: 0x20C ----
    frag_pc_reg_t frag_pc;

    // ---- DMA DRAM Base Address: 0x210 — nogen on FPGA (hasDMA=false) ----
    dma_dram_reg_t dma_dram;
    dma_dram->nogen = true;

    // ---- DMA Configuration + Trigger: 0x214 — nogen on FPGA (hasDMA=false) ----
    dma_config_reg_t dma_config;
    dma_config->nogen = true;

    // ---- Flush Framebuffer Base Address: 0x218 — nogen (decoded in Borg.scala) ----
    flush_fb_base_reg_t flush_fb_base;
    flush_fb_base->nogen = true;

    // ---- Flush Z-buffer Base Address: 0x21C — nogen (decoded in Borg.scala) ----
    flush_zb_base_reg_t flush_zb_base;
    flush_zb_base->nogen = true;

    // ---- Flush Framebuffer Width: 0x21C — nogen (decoded in Borg.scala) ----
    flush_width_reg_t flush_width;
    flush_width->nogen = true;

    // ---- Sequencer Descriptor Base Address: 0x220 — nogen (decoded in Borg.scala) ----
    seq_desc_base_reg_t seq_desc_base;
    seq_desc_base->nogen = true;

    // ---- Sequencer Trigger: 0x224 — nogen (decoded in Borg.scala) ----
    seq_trigger_reg_t seq_trigger;
    seq_trigger->nogen = true;

    // ---- Sequencer Vertex Shader Address: 0x228 — nogen (Step 29.1) ----
    seq_vert_addr_reg_t seq_vert_addr;
    seq_vert_addr->nogen = true;

    // ---- Sequencer Vertex Shader Length: 0x22C — nogen (Step 29.1) ----
    seq_vert_len_reg_t seq_vert_len;
    seq_vert_len->nogen = true;

    // ---- Sequencer Setup Shader Address: 0x230 — nogen (Step 29.2) ----
    seq_setup_addr_reg_t seq_setup_addr;
    seq_setup_addr->nogen = true;

    // ---- Sequencer Setup Shader Length: 0x234 — nogen (Step 29.2) ----
    seq_setup_len_reg_t seq_setup_len;
    seq_setup_len->nogen = true;

    // ---- Sequencer Inverse Width: 0x238 — nogen (Step 30.1c) ----
    seq_inv_width_reg_t seq_inv_width;
    seq_inv_width->nogen = true;

    // ---- Sequencer Triangle Count: 0x23C — nogen (Step 31) ----
    seq_tri_count_reg_t seq_tri_count;
    seq_tri_count->nogen = true;

    // ---- Sequencer Rast Shader Address: 0x240 — nogen (Step 31) ----
    seq_rast_addr_reg_t seq_rast_addr;
    seq_rast_addr->nogen = true;

    // ---- Sequencer Rast Shader Length: 0x244 — nogen (Step 31) ----
    seq_rast_len_reg_t seq_rast_len;
    seq_rast_len->nogen = true;

    // ---- Sequencer Frag Shader Address: 0x248 — nogen (Step 31) ----
    seq_frag_addr_reg_t seq_frag_addr;
    seq_frag_addr->nogen = true;

    // ---- Sequencer Frag Shader Length: 0x24C — nogen (Step 31) ----
    seq_frag_len_reg_t seq_frag_len;
    seq_frag_len->nogen = true;

    // ---- Sequencer Clear Color Low: 0x250 — nogen (Step 31) ----
    seq_clear_lo_reg_t seq_clear_lo;
    seq_clear_lo->nogen = true;

    // ---- Sequencer Clear Color High: 0x254 — nogen (Step 31) ----
    seq_clear_hi_reg_t seq_clear_hi;
    seq_clear_hi->nogen = true;

    // ---- Sequencer Framebuffer Base Address: 0x258 — nogen (Step 31.4) ----
    seq_fb_base_reg_t seq_fb_base;
    seq_fb_base->nogen = true;

    // ---- Sequencer Tiles Per Row: 0x25C — nogen (Step 31.4) ----
    seq_tiles_per_row_reg_t seq_tiles_per_row;
    seq_tiles_per_row->nogen = true;

    // ---- Sequencer Bin List Base: 0x260 — nogen (Step 32.2) ----
    seq_bin_base_reg_t seq_bin_base;
    seq_bin_base->nogen = true;

    // ---- Sequencer Bin Row Bytes: 0x264 — nogen (Step 32.2) ----
    seq_bin_row_bytes_reg_t seq_bin_row_bytes;
    seq_bin_row_bytes->nogen = true;

    // ---- Sequencer Setup Store Base: 0x268 — nogen (Step 32.3) ----
    seq_setup_base_reg_t seq_setup_base;
    seq_setup_base->nogen = true;

    // ---- Performance counters: present-phase decomposition ----
    // Fully generated (hw=w → Borg drives io.hw.perf_*_value, SW reads).
    perf_counter_reg_t perf_total;   // 0x26C: sequencer-active cycles (present total)
    perf_counter_reg_t perf_frag;    // 0x270: shader core running (vert+setup+frag)
    perf_counter_reg_t perf_flush;   // 0x274: tile flusher active (SDRAM writes)
    perf_counter_reg_t perf_stall;   // 0x278: gpuMem.req && !ready (SDRAM stall)
    perf_counter_reg_t perf_dma;     // 0x27C: DMA active (bin/descriptor reads)
};
