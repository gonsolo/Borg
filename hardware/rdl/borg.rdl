// SPDX-FileCopyrightText: © 2026 Andreas Wendleder
// SPDX-License-Identifier: CERN-OHL-S-2.0
//
// Borg GPU — SystemRDL 2.0 Register Description
//
// This file is the machine-parsable single source of truth for the Borg GPU
// MMIO register map.  It mirrors the constants defined in MmioMap.scala and
// is intended to replace them via PeakRDL code generation (Step 14).
//
// Address space: 1024 bytes (10-bit byte address), 32-bit data bus.
// All registers are 32-bit aligned (4-byte stride).
//
// Offset computation (matches Chisel):
//   REG_FILE:     0x000 – 0x07C  (32 × 4 = 128 bytes)
//   IMEM:         0x080 – 0x19C  (72 × 4 = 288 bytes)
//   ITER:         0x1A4
//   CONTROL:      0x1A8  (write: control, read: status — same address)
//   STATUS:       0x1AC
//   UNIFORM[0]:   0x1B0 – 0x22C  (32 × 4 = 128 bytes, MMIO window = 1 page)
//   TILE_CTRL:    0x230
//   TILE_RG:      0x234
//   TILE_BZ:      0x238
//   CMD_ENQUEUE:  0x23C

// ============================================================================
// User-defined properties
// ============================================================================

// nogen: when true on a register instance, suppresses hardware synthesis for
// that register.  The offset constant is still emitted for firmware
// compatibility; writes to the MMIO address are silently ignored by hardware.
property nogen { type = boolean; default = false; component = reg; };

// ============================================================================
// Field / Register type definitions
// ============================================================================

// --- Coordinate (10-bit x/y pair, matches Chisel Coord bundle) ---
field coord_field_t {
    sw = rw; hw = r;
    fieldwidth = 10;
};

// --- Iterator read-back ---
// Bit layout: {rsvd[31:22], inside[21], valid[20], y[19:10], x[9:0]}
reg iter_reg_t {
    name = "Pixel Iterator Position";
    desc = "Read: current iterator position plus valid/inside flags.
            Write: advance the iterator by one pixel (data ignored).";

    field {
        sw = r; hw = w;
        desc = "Current pixel X coordinate (10-bit).";
    } x[10] = 0;

    field {
        sw = r; hw = w;
        desc = "Current pixel Y coordinate (10-bit).";
    } y[10] = 0;

    field {
        sw = r; hw = w;
        desc = "Iterator valid flag — 1 while inside bounding box.";
    } valid[1] = 0;

    field {
        sw = r; hw = w;
        desc = "Inside flag — 1 if current pixel passes all 3 edge tests.";
    } inside_flag[1] = 0;

    field {
        sw = r; hw = na;
    } RSVD[10] = 0;
};

// --- Control register (write path) ---
// The control and status registers share the same address (0x1A8).
// A write drives the control fields; a read returns the status fields.
reg control_reg_t {
    name = "GPU Control";
    desc = "Write: start execution, reset pipeline, set uniform write page and
            start PC.  Bits are active-high, self-clearing where noted.";

    field {
        sw = w; hw = r;
        singlepulse;
        desc = "Bit 0: Start shader execution (self-clearing pulse).";
    } start[1] = 0;

    field {
        sw = w; hw = r;
        singlepulse;
        desc = "Bit 1: Reset the pipeline (self-clearing pulse).";
    } reset_pipeline[1] = 0;

    field {
        sw = w; hw = na;
        desc = "Bits 4:2: Reserved.";
    } RSVD_ctl[3] = 0;

    field {
        sw = w; hw = r;
        desc = "Bit 5: Select which uniform buffer page (0 or 1) MMIO writes
                target.  The GPU reads from the page specified per-command by
                the Command FIFO entry's uniformPage field.";
    } uniform_write_page[1] = 0;

    field {
        sw = w; hw = r;
        desc = "Bits 12:6: Shader start PC (7-bit program counter offset into
                IMEM).  Widened 6->7 bits for IMEM=72 (the scalar-FPU helper
                program lives at IMEM[70], past the 56-word borgc fragment); a
                6-bit field truncated PC>=64 to PC&0x3F, silently mis-starting
                borg_fp16_mul/add/fmadd/rcp and zeroing all CPU-side fp16 math.";
    } start_pc[7] = 0;

    field {
        sw = w; hw = na;
    } RSVD_hi[19] = 0;
};

// --- Status register (read path at same address as CONTROL) ---
reg status_reg_t {
    name = "GPU Status";
    desc = "Read-only status at the same address as CONTROL (0x1A8).
            Hardware returns this value on read; writes go to control_reg_t.";

    field {
        sw = r; hw = w;
        desc = "Bit 0: Reserved (always 0).";
    } RSVD0[1] = 0;

    field {
        sw = r; hw = w;
        desc = "Bit 1: Idle — 1 when the shader pipeline is not running.";
    } idle[1] = 0;

    field {
        sw = r; hw = w;
        desc = "Bit 2: FIFO full — 1 when the Command FIFO cannot accept
                another entry.  Firmware must poll this before enqueue.";
    } fifo_full[1] = 0;

    field {
        sw = r; hw = w;
        desc = "Bit 3: DMA busy — 1 while the DMA engine is transferring data
                from DRAM to IMEM or the uniform buffer.";
    } dma_busy[1] = 0;

    field {
        sw = r; hw = w;
        desc = "Bit 4: Flush busy — 1 while BorgTileFlusher is writing tile
                pixels to DRAM.  Firmware polls this bit instead of doing
                manual DRAM writes (Step 25.3h).";
    } flush_busy[1] = 0;

    field {
        sw = r; hw = w;
        desc = "Bit 5: Sequencer busy — 1 while BorgSequencer is processing a
                vertex/setup shader sequence (Step 29).  Firmware polls this
                bit after triggering SEQ_TRIGGER to know when the GPU has
                finished computing uniforms and is ready for tile commands.";
    } seq_busy[1] = 0;

    field {
        sw = r; hw = w;
        desc = "Bit 6: Branch divergence — sticky, set when a BRZ/BRNZ
                condition differed between lanes of a 2x2 quad. The quad
                shares one program counter, so such a branch cannot be
                executed correctly by any choice the hardware could make;
                the contract is that branch conditions are quad-uniform, and
                this bit exists so a violation is observable instead of
                silently producing a wrong image. Always 0 at fragLanes=1.
                Cleared by a core reset.";
    } branch_divergent[1] = 0;

    field {
        sw = r; hw = w;
        desc = "Bit 7: Execution-mask fault — sticky, set when the
                EXPUSH/EXPOP stack over- or underflowed, i.e. a shader's
                mask push/pop pairs are unbalanced or nested deeper than 8.
                Any such program produces wrong results; this makes that
                detectable rather than silent. Cleared by a core reset.";
    } exec_fault[1] = 0;

    field {
        sw = r; hw = na;
    } RSVD_hi[24] = 0;
};

// --- Fragment shader start PC ---
reg frag_pc_reg_t {
    name = "Fragment Shader Start PC";
    desc = "Write the IMEM entry point for the fragment shader.  The rasterizer
            auto-chains to this PC after the rasterize shader completes for an
            inside pixel.";

    field {
        sw = rw; hw = r;
        desc = "6-bit fragment shader program counter.";
    } frag_pc[6] = 0;

    field {
        sw = rw; hw = na;
    } RSVD[26] = 0;
};

// --- DMA DRAM base address (Step 22.1) ---
reg dma_dram_reg_t {
    name = "DMA DRAM Base Address";
    desc = "DRAM byte address of the first word to transfer.  Must be
            4-byte aligned.  Write before triggering DMA_CONFIG.start.";

    field {
        sw = rw; hw = r;
        desc = "Bits 19:0: 20-bit DRAM byte address.";
    } base[20] = 0;

    field {
        sw = rw; hw = na;
    } RSVD[12] = 0;
};

// --- DMA transfer config + trigger (Step 22.1) ---
reg dma_config_reg_t {
    name = "DMA Configuration";
    desc = "Configures and triggers a bulk DMA transfer from DRAM into
            IMEM or the uniform buffer.  Write DMA_ADDR first, then write
            this register with start=1 to launch the transfer.  Poll
            STATUS.dma_busy (bit 3) for completion.";

    field {
        sw = w; hw = r;
        singlepulse;
        desc = "Bit 0: Start DMA transfer (self-clearing pulse).";
    } start[1] = 0;

    field {
        sw = rw; hw = r;
        desc = "Bits 6:1: Number of 32-bit words to transfer (1–56 for IMEM,
                1–32 for uniforms).";
    } length[6] = 0;

    field {
        sw = rw; hw = r;
        desc = "Bits 8:7: Destination buffer.
                0=IMEM, 1=Uniform-page0, 2=Uniform-page1.";
    } dest[2] = 0;

    field {
        sw = rw; hw = r;
        desc = "Bits 14:9: Starting word index in the destination buffer.";
    } offset[6] = 0;

    field {
        sw = rw; hw = na;
    } RSVD[17] = 0;
};

// --- Tile buffer CTRL ---
// Write: bits[3:0] = pixel index (triggers BRAM read), bit[4] = clear.
reg tile_ctrl_reg_t {
    name = "Tile Buffer Control";
    desc = "Write to set the tile buffer read index or trigger a clear.
            Setting bit 4 clears the entire 4×4 tile buffer.";

    field {
        sw = w; hw = r;
        desc = "Bits 3:0: Tile buffer pixel index (0–15) for read-back.
                Writing this triggers a BRAM read; data is available at
                TILE_RG / TILE_BZ on the next cycle.";
    } read_idx[4] = 0;

    field {
        sw = w; hw = r;
        singlepulse;
        desc = "Bit 4: Clear — writing 1 clears all 16 tile entries.";
    } clear[1] = 0;

    field {
        sw = w; hw = na;
    } RSVD[27] = 0;
};

// --- Tile buffer RG read-back ---
// Read: {R[31:16], G[15:0]} of the indexed pixel.
// Write: triggers a tile buffer write (with values from BZ shadow + this RG).
reg tile_rg_reg_t {
    name = "Tile Buffer RG";
    desc = "Read: packed {R[31:16], G[15:0]} of the tile pixel selected by
            TILE_CTRL.read_idx.
            Write: combined with BZ shadow registers to write a full RGBZ pixel.";

    field {
        sw = rw; hw = r;
        desc = "Green channel (FP16, bits 15:0).";
    } g[16] = 0;

    field {
        sw = rw; hw = r;
        desc = "Red channel (FP16, bits 31:16).";
    } red[16] = 0;
};

// --- Tile buffer BZ read-back / shadow ---
// Read: {B[31:16], Z[15:0]} of the indexed pixel.
// Write: latches B and Z into shadow registers for the next RG write trigger.
reg tile_bz_reg_t {
    name = "Tile Buffer BZ";
    desc = "Read: packed {B[31:16], Z[15:0]} of the tile pixel selected by
            TILE_CTRL.read_idx.
            Write: latches B and Z into shadow registers; the actual tile buffer
            write is triggered by the subsequent TILE_RG write.";

    field {
        sw = rw; hw = r;
        desc = "Depth channel (FP16, bits 15:0).";
    } z[16] = 0;

    field {
        sw = rw; hw = r;
        desc = "Blue channel (FP16, bits 31:16).";
    } b[16] = 0;
};

// --- Command FIFO enqueue ---
// Write: {rsvd[31:20], tile_y[19:10], tile_x[9:0]}
// frag_pc and uniform_page are read from their dedicated registers.
reg cmd_enqueue_reg_t {
    name = "Command FIFO Enqueue";
    desc = "Write-only.  Push a rasterization command into the 2-entry Command
            FIFO.  The command specifies the 4×4 tile origin (in pixel coords).
            frag_pc comes from FRAG_PC register; uniform page from CONTROL.
            Poll STATUS.fifo_full before writing.";

    field {
        sw = w; hw = r;
        desc = "Bits 9:0: Tile origin X (10-bit pixel coordinate, 4-aligned).";
    } tile_x[10] = 0;

    field {
        sw = w; hw = r;
        desc = "Bits 19:10: Tile origin Y (10-bit pixel coordinate, 4-aligned).";
    } tile_y[10] = 0;

    field {
        sw = w; hw = na;
    } RSVD[12] = 0;
};

// tex_uv_reg_t removed: hardware now uses rasterizer UV snoop; firmware never writes this register.

// --- Texture configuration (Step 21.2) ---
// Write: set texture DRAM base address and enable hardware texel fetch.
reg tex_config_reg_t {
    name = "Texture Configuration";
    desc = "Configures the hardware sTexFetch path.  Write base_addr and en
            before submitting textured draw commands.  base_addr is a 16-bit
            word index (×8 for byte offset, matching the 8-byte-per-texel layout).
            Set en=1 to enable autonomous texel fetches after each fragment shade.";

    field {
        sw = rw; hw = r;
        desc = "Bits 15:0: DRAM base address of the texture (16-bit word index).";
    } base_addr[16] = 0;

    field {
        sw = rw; hw = r;
        desc = "Bit 16: Enable hardware texel fetch (sTexFetch FSM).  0=disabled.";
    } en[1] = 0;

    field {
        sw = rw; hw = r;
        desc = "Bit 17: Fragment uniform-staging mode for u19-u27.  0 = vertex
                colour R/G/B (the hand-written frag.s, outColor = texel*color);
                1 = per-vertex model position frag_pos.x/y/z (the borgc cube.frag,
                which derives the normal via dFdx/dFdy(frag_pos)).  Set by the
                firmware to match the loaded fragment shader.";
    } frag_uses_fragpos[1] = 0;

    field {
        sw = rw; hw = r;
        desc = "Bits 21:18: log2 of the texture dimension (e.g. 6 for 64×64,
                8 for 256×256).  Used by the hardware to clamp tex_x and tex_y
                to [0, 2^log2_dim − 1], preventing UV=1.0 from sampling beyond
                the last texture row/column.  Set to 0 to disable clamping.";
    } log2_dim[4] = 0;

    field {
        sw = rw; hw = na;
    } RSVD[10] = 0;
};

// --- Multi-texture binding: per-slot DRAM base address ---
//
// FTEX's rs3 operand (see hardware/borg/src/Instructions.scala's
// FUNCT2_FTEX) selects which of these the hardware reads for a given
// sample. Only the base address is per-slot; tex_config's dimension,
// address-mode and filtering fields stay shared across every bound
// texture -- a real scoping limit (every simultaneously-bound texture
// must be the same size), not an oversight. tex_config.base_addr itself
// is superseded by slot 0 here and no longer read by hardware, but is
// left defined above rather than removed, matching this file's existing
// convention for retired-but-still-firmware-visible fields (see tex_addr's
// own comment below).
//
// Four SEPARATE registers, deliberately not a SystemRDL array: an array
// this small still gets PeakRDL-chisel's generic array backing (a
// SyncReadMem with a 1-cycle-latency read port), which is the wrong
// timing for a value that must be valid combinationally alongside FTEX's
// texU/texV in the same cycle -- the same reason ls_base and every other
// small always-on register in this file is its own named reg, not a[1].
reg tex_base_addr_reg_t {
    name = "Texture Base Address (per binding slot)";
    desc = "Same encoding as the superseded tex_config.base_addr: a 16-bit
            word index (×8 for byte offset, matching the 8-byte-per-texel
            layout). Which slot's register is read is selected in hardware
            by FTEX's rs3 operand.";

    field {
        sw = rw; hw = r;
        desc = "Bits 15:0: DRAM base address of this slot's texture (16-bit word index).";
    } base_addr[16] = 0;

    field {
        sw = rw; hw = na;
    } RSVD[16] = 0;
};

// --- Colour attachment format written by the tile flusher ---
// RGB565 alone cannot be every colour attachment: R8G8B8A8_UNORM and
// B8G8R8A8_UNORM are mandatory COLOR_ATTACHMENT formats, and the swapchain
// format is almost always the latter. The tile buffer already holds UNORM8
// R/G/B plus a UNORM8 alpha plane, so the wider formats are a packing choice
// at flush time, not new storage.
reg flush_format_reg_t {
    name = "Flush Colour Format";
    desc = "Colour format of the attachment the tile flusher writes. Reset 0
            is the historical RGB565 (32 bytes per 4x4 tile); the 32-bit
            formats take 64 bytes per tile, so the autonomous sequencer's tile
            stride doubles with them. Depth tiles stay 32 bytes (D16_UNORM).";

    field {
        sw = rw; hw = r;
        desc = "0 = R5G6B5_UNORM_PACK16, 1 = R8G8B8A8_UNORM, 2 = B8G8R8A8_UNORM,
                3 = reserved (behaves as 0).";
    } format[2] = 0;

    field {
        sw = rw; hw = na;
    } RSVD[30] = 0;
};

// --- Shader program image in DRAM (instruction cache backing store) ---
// With BorgConfig.hasShaderICache, IMEM is a cache over the running program,
// whose word `pc` lives at code_base + 4*pc. Every shader DMA into IMEM sets
// this automatically (to the DMA source minus 4 x its IMEM offset), so a
// sequencer-driven render never needs to write it; it is for programs loaded
// over MMIO that are longer than IMEM. Any write, and any shader DMA into
// IMEM, starts a new program and invalidates the whole cache -- so write it
// BEFORE the program's IMEM words, which then prefill it.
reg code_base_reg_t {
    name = "Shader Code Base";
    desc = "Byte address in GPU memory of word 0 of the running shader
            program (4-byte aligned). nogen: decoded from the raw bus by
            Borg.scala, only in a build with the instruction cache.";

    field {
        sw = rw; hw = r;
        desc = "Bits 24:0: byte address of program word 0.";
    } base_addr[25] = 0;

    field {
        sw = rw; hw = na;
    } RSVD[7] = 0;
};

// --- Occlusion queries -------------------------------------------------
// OCC_COUNT counts samples that pass the per-fragment tests (depth, stencil,
// scissor, coverage, not discarded) -- exactly, so occlusionQueryPrecise can
// be reported. Counted where the tests run: at ZTEST for a shader with early
// tests, at the end of the shader otherwise.
//
// A tile-based renderer interleaves fragments of every draw tile by tile, so
// "while the query is active" cannot be a time window. It is a triangle
// window instead: only fragments of triangles with first <= index < last are
// counted (the reset window, 0..0xFFFF, counts everything). One window per
// render: the driver maps vkCmdBeginQuery/EndQuery to the triangle range of
// the draws between them.
reg occ_ctrl_reg_t {
    name = "Occlusion Query Control";
    desc = "nogen: decoded from the raw bus by Borg.scala.";
    field { sw = rw; hw = r; desc = "Count passing samples."; } enable[1] = 0;
    field { sw = w;  hw = r; desc = "Write 1: reset OCC_COUNT to 0."; } clear[1] = 0;
    field { sw = rw; hw = na; } RSVD[30] = 0;
};
reg occ_tri_range_reg_t {
    name = "Occlusion Query Triangle Window";
    desc = "nogen. Triangles counted: first <= index < last.";
    field { sw = rw; hw = r; desc = "First counted triangle index."; } first[16] = 0;
    field { sw = rw; hw = r; desc = "One past the last counted triangle index."; } last[16] = 0xFFFF;
};
reg occ_count_reg_t {
    name = "Occlusion Query Count";
    desc = "nogen, read-only: samples that passed the per-fragment tests.";
    field { sw = r; hw = w; desc = "Passing-sample count."; } count[32] = 0;
};

// --- Texture address (computed by hardware) ---
// Read: Morton-encoded texel index from the most recent tex_uv write.
reg tex_addr_reg_t {
    name = "Texture Address";
    desc = "Read-only.  Returns the Morton-encoded 16-bit texel index computed
            from the most recent tex_uv write, plus raw uint8 coordinates.";

    field {
        sw = r; hw = w;
        desc = "Bits 15:0: Morton-encoded texel index.";
    } morton[16] = 0;

    field {
        sw = r; hw = w;
        desc = "Bits 23:16: Raw uint8 U coordinate.";
    } raw_u[8] = 0;

    field {
        sw = r; hw = w;
        desc = "Bits 31:24: Raw uint8 V coordinate.";
    } raw_v[8] = 0;
};

// --- Tile flusher framebuffer base address (Step 25.3h) ---
reg flush_fb_base_reg_t {
    name = "Flush Framebuffer Base Address";
    desc = "20-bit DRAM byte address of the framebuffer base.
            Written by firmware at startup; read by BorgTileFlusher on every
            tile flush.  nogen: decoded from the raw bus by Borg.scala.";

    field {
        sw = rw; hw = r;
        desc = "Bits 19:0: 20-bit DRAM byte address of framebuffer base.";
    } fb_base[20] = 0;

    field {
        sw = rw; hw = na;
    } RSVD[12] = 0;
};

// --- Depth test configuration (Step 50 item 11) ---
reg depth_cfg_reg_t {
    name = "Depth Test Configuration";
    desc = "Per-pipeline depth state. Vulkan requires all 8 VkCompareOp values
            to be selectable for the depth test (no feature bit gates it), and
            requires depthWriteEnable; the hardware previously hardcoded LESS
            with depth always written on pass. Reset values reproduce that
            historical behaviour exactly, so firmware that never writes this
            register is unaffected.";

    field {
        sw = rw; hw = r;
        desc = "Bits 2:0: VkCompareOp for the depth test. 0=NEVER, 1=LESS,
                2=EQUAL, 3=LESS_OR_EQUAL, 4=GREATER, 5=NOT_EQUAL,
                6=GREATER_OR_EQUAL, 7=ALWAYS. Reset 1 (LESS) is the historical
                hardcoded comparison.";
    } compare_op[3] = 1;

    field {
        sw = rw; hw = r;
        desc = "Bit 3: depthWriteEnable. 1 = a passing fragment updates the
                stored Z (historical behaviour); 0 = depth is tested but never
                written, which Vulkan requires for depth-read-only passes.";
    } write_en[1] = 1;

    field {
        sw = rw; hw = na;
    } RSVD[28] = 0;
};

// --- Colour blend configuration (Step 50 item 9) ---
reg blend_cfg_reg_t {
    name = "Blend Configuration";
    desc = "Fixed-function colour blend state, laid out to match
            VkPipelineColorBlendAttachmentState so the driver passes the
            Vulkan enum values through with no translation table.

            Blending is core Vulkan functionality -- only independentBlend
            and dualSrcBlend are the optional extras. Reset 0 disables it,
            which is the historical unconditional-overwrite behaviour, so
            firmware that never writes this register is unaffected.

            Factor encodings are VkBlendFactor 0..14; the SRC1_* values
            (15..18) belong to the optional dualSrcBlend feature and are not
            implemented. Op encodings are VkBlendOp 0..4 (ADD, SUBTRACT,
            REVERSE_SUBTRACT, MIN, MAX).";

    field {
        sw = rw; hw = r;
        desc = "Bit 0: blendEnable. 0 = the fragment colour overwrites the
                destination (and skips the UNORM8 round trip entirely).";
    } enable[1] = 0;

    field {
        sw = rw; hw = r;
        desc = "Bits 5:1: srcColorBlendFactor (VkBlendFactor).";
    } src_color_factor[5] = 0;

    field {
        sw = rw; hw = r;
        desc = "Bits 10:6: dstColorBlendFactor (VkBlendFactor).";
    } dst_color_factor[5] = 0;

    field {
        sw = rw; hw = r;
        desc = "Bits 13:11: colorBlendOp (VkBlendOp).";
    } color_op[3] = 0;

    field {
        sw = rw; hw = r;
        desc = "Bits 18:14: srcAlphaBlendFactor (VkBlendFactor).";
    } src_alpha_factor[5] = 0;

    field {
        sw = rw; hw = r;
        desc = "Bits 23:19: dstAlphaBlendFactor (VkBlendFactor).";
    } dst_alpha_factor[5] = 0;

    field {
        sw = rw; hw = r;
        desc = "Bits 26:24: alphaBlendOp (VkBlendOp).";
    } alpha_op[3] = 0;

    field {
        sw = rw; hw = r;
        desc = "Bits 30:27: colorWriteMask (VkColorComponentFlagBits) -- bit 0
                R, 1 G, 2 B, 3 A. A masked-off channel keeps the destination's
                value. Independent of `enable`: Vulkan applies the write mask
                whether or not blending is on, which is what makes it usable
                for the depth-only and channel-isolating passes it exists for.
                Reset 0xF = write every channel, the historical behaviour.
                The A bit has nothing to act on -- Borg's colour attachment
                stores no alpha -- so masking it is already what happens.";
    } color_write_mask[4] = 15;

    field {
        sw = rw; hw = na;
    } RSVD[1] = 0;
};

reg blend_const_reg_t {
    name = "Blend Constant Colour";
    desc = "VkPipelineColorBlendStateCreateInfo::blendConstants, as UNORM8
            components -- the value the CONSTANT_COLOR / CONSTANT_ALPHA
            blend factors select. Blending is performed in UNORM8, so this
            is the natural encoding rather than four floats.";

    field { sw = rw; hw = r; desc = "Bits 7:0: R."; }   const_r[8] = 0;
    field { sw = rw; hw = r; desc = "Bits 15:8: G."; }  const_g[8] = 0;
    field { sw = rw; hw = r; desc = "Bits 23:16: B."; } const_b[8] = 0;
    field { sw = rw; hw = r; desc = "Bits 31:24: A."; } const_a[8] = 0;
};

// --- Stencil test configuration (Step 50 item 10) ---
reg stencil_cfg_reg_t {
    name = "Stencil Configuration";
    desc = "Stencil enable plus both faces' VkStencilOpState op fields.
            Vulkan always has independent front/back stencil state -- no
            feature bit makes them share -- so both faces live in the
            datapath rather than being swapped between draws.

            Compare ops are VkCompareOp 0..7 (the same encoding DEPTH_CFG
            uses); stencil ops are VkStencilOp 0..7: 0=KEEP, 1=ZERO,
            2=REPLACE, 3=INCREMENT_AND_CLAMP, 4=DECREMENT_AND_CLAMP,
            5=INVERT, 6=INCREMENT_AND_WRAP, 7=DECREMENT_AND_WRAP.

            Reset 0 disables stencil entirely, reproducing the historical
            no-stencil behaviour.

            NOTE: back-face state is currently unreachable. The geometry
            sequencer culls back-facing triangles before rasterization, so
            every fragment is front-facing; two-sided stencil needs
            configurable cull mode (VK_CULL_MODE_NONE) first.";

    field { sw = rw; hw = r; desc = "Bit 0: stencilTestEnable."; } enable[1] = 0;

    field { sw = rw; hw = r; desc = "Bits 3:1: front compareOp (VkCompareOp)."; }
        front_compare_op[3] = 0;
    field { sw = rw; hw = r; desc = "Bits 6:4: front failOp (VkStencilOp)."; }
        front_fail_op[3] = 0;
    field { sw = rw; hw = r; desc = "Bits 9:7: front passOp (VkStencilOp)."; }
        front_pass_op[3] = 0;
    field { sw = rw; hw = r; desc = "Bits 12:10: front depthFailOp (VkStencilOp)."; }
        front_depth_fail_op[3] = 0;

    field { sw = rw; hw = r; desc = "Bits 15:13: back compareOp (VkCompareOp)."; }
        back_compare_op[3] = 0;
    field { sw = rw; hw = r; desc = "Bits 18:16: back failOp (VkStencilOp)."; }
        back_fail_op[3] = 0;
    field { sw = rw; hw = r; desc = "Bits 21:19: back passOp (VkStencilOp)."; }
        back_pass_op[3] = 0;
    field { sw = rw; hw = r; desc = "Bits 24:22: back depthFailOp (VkStencilOp)."; }
        back_depth_fail_op[3] = 0;

    field { sw = rw; hw = na; } RSVD[7] = 0;
};

reg plane_clear_reg_t {
    name = "Auxiliary Plane Clear Values";
    desc = "Clear values for the tile buffer's two auxiliary planes -- the
            stencil plane and the destination-alpha plane. Neither fits in
            the existing SEQ_CLEAR_LO/HI pair (that is fully occupied by
            R/G/B/Z) and neither had enough spare bits in its own config
            register, so both live here.

            The alpha reset is 0xFF, not 0: an opaque destination is what the
            hardware behaved as before the alpha plane existed, so an
            alpha-capable build that never writes this register renders
            exactly like one without it.";

    field {
        sw = rw; hw = r;
        desc = "Bits 7:0: stencil clear value (VkClearDepthStencilValue::stencil).";
    } stencil[8] = 0;

    field {
        sw = rw; hw = r;
        desc = "Bits 15:8: destination alpha clear value, UNORM8
                (VkClearColorValue alpha). Reset 0xFF = opaque.";
    } alpha[8] = 255;

    field { sw = rw; hw = na; } RSVD[16] = 0;
};

reg stencil_face_reg_t {
    name = "Stencil Face Masks";
    desc = "One face's compareMask, writeMask and reference. These are the
            three pieces of stencil state Vulkan lets an application change
            without rebuilding the pipeline (VK_DYNAMIC_STATE_STENCIL_*),
            which is why they sit in their own register.";

    field { sw = rw; hw = r; desc = "Bits 7:0: compareMask."; }   compare_mask[8] = 0;
    field { sw = rw; hw = r; desc = "Bits 15:8: writeMask."; }    write_mask[8] = 0;
    field { sw = rw; hw = r; desc = "Bits 23:16: reference."; }   reference[8] = 0;
    field { sw = rw; hw = na; } RSVD[8] = 0;
};

// --- Face culling configuration (Step 50) ---
reg cull_cfg_reg_t {
    name = "Face Culling Configuration";
    desc = "Configurable face culling. Vulkan requires all four
            VkCullModeFlagBits values (NONE, FRONT, BACK, FRONT_AND_BACK)
            and both VkFrontFace windings; the hardware previously always
            culled back-facing triangles with no way to change it, so
            VK_CULL_MODE_NONE -- needed by any two-sided draw, and the
            precondition for two-sided stencil ever doing anything -- was
            simply unavailable.

            Reset values reproduce the historical always-cull-back
            behaviour, so firmware that never writes this register is
            unaffected.";

    field {
        sw = rw; hw = r;
        desc = "Bits 1:0: VkCullModeFlagBits -- bit 0 culls front faces,
                bit 1 culls back faces. 0 = NONE (no culling), 3 =
                FRONT_AND_BACK (everything culled). Reset 2 = BACK, the
                historical hardcoded behaviour.";
    } cull_mode[2] = 2;

    field {
        sw = rw; hw = r;
        desc = "Bit 2: invert the facing determination. 0 keeps the
                historical convention (the setup shader's signed area sign
                bit means back-facing); 1 swaps front and back.

                Deliberately named 'invert' rather than exposing VkFrontFace
                directly: which of CLOCKWISE / COUNTER_CLOCKWISE the current
                setup shader's winding corresponds to has not been confirmed
                by experiment, and guessing the mapping here would bake a
                coin flip into the register map. The driver needs one
                two-triangle test to pin it down, after which this can be
                documented as the VkFrontFace bit it actually is.";
    } front_face_invert[1] = 0;

    field { sw = rw; hw = na; } RSVD[29] = 0;
};

// --- Scissor rectangle (Step 50) ---
reg scissor_x_reg_t {
    name = "Scissor Rectangle X";
    desc = "Scissor test X bounds, in pixels. x0 is inclusive, x1 exclusive,
            so a VkRect2D maps directly: x0 = offset.x, x1 = offset.x +
            extent.width.

            The scissor test is core Vulkan -- every graphics pipeline has a
            scissor rectangle, there is no feature bit and no way to opt out
            of the state -- and Borg had none: a fragment inside the triangle
            was always written.

            13 bits per bound, not 12: the bounds are half-open, so covering
            the full 4096-wide framebuffer Vulkan requires needs x1 = 4096,
            which does not fit in 12 bits.";

    field { sw = rw; hw = r; desc = "Bits 12:0: x0, inclusive."; }  x0[13] = 0;
    field { sw = rw; hw = r; desc = "Bits 25:13: x1, exclusive."; } x1[13] = 0;
    field { sw = rw; hw = na; } RSVD[6] = 0;
};

reg scissor_y_reg_t {
    name = "Scissor Rectangle Y";
    desc = "Scissor test Y bounds plus the enable. y0 inclusive, y1
            exclusive, matching scissor_x.";

    field { sw = rw; hw = r; desc = "Bits 12:0: y0, inclusive."; }  y0[13] = 0;
    field { sw = rw; hw = r; desc = "Bits 25:13: y1, exclusive."; } y1[13] = 0;
    field {
        sw = rw; hw = r;
        desc = "Bit 26: scissor enable. Reset 0 -- every fragment passes, the
                historical behaviour. An enable bit rather than resetting the
                bounds wide open, so firmware that zeroes the register block
                does not silently discard the whole frame.";
    } enable[1] = 0;
    field { sw = rw; hw = na; } RSVD[5] = 0;
};

// --- Load/store base address (Step 50) ---
reg ls_base_reg_t {
    name = "Load/Store Base Address";
    desc = "Base DRAM byte address that the LOAD and STORE shader
            instructions are relative to. Effectively an SSBO descriptor: the
            shader supplies an element index, the hardware forms
            LS_BASE + (index << 2).

            The operand cannot be a full address. At FP16 a shader register
            holds 16 bits and the GPU address space is 25, so a register
            physically cannot carry one -- hence base-plus-index, which is
            also the shape the texture unit already uses and the shape a
            Vulkan descriptor binding naturally has.

            Reset 0. Nothing reads this until a shader actually executes a
            LOAD or STORE, so firmware that never writes it is unaffected.";

    field {
        sw = rw; hw = r;
        desc = "Bits 24:0: base DRAM byte address (32 MB space).";
    } base_addr[25] = 0;

    field { sw = rw; hw = na; } RSVD[7] = 0;
};

// --- Sampler configuration (Step 50) ---
reg sampler_cfg_reg_t {
    name = "Sampler Configuration";
    desc = "Texture sampler state. Linear filtering is core Vulkan -- no
            feature bit gates VK_FILTER_LINEAR -- and Borg sampled
            nearest-neighbour only.

            Reset 0 (NEAREST) reproduces the historical behaviour exactly,
            including skipping the UNORM8 round trip the filtered path uses,
            so firmware that never writes this register is unaffected.";

    field {
        sw = rw; hw = r;
        desc = "Bit 0: VkFilter for magnification and minification alike --
                0 = VK_FILTER_NEAREST, 1 = VK_FILTER_LINEAR. Vulkan carries
                magFilter and minFilter separately; Borg has no LOD selection
                yet, so there is no minification path to filter differently
                and one bit covers both. Splitting them belongs with mipmap
                support, not before it.";
    } filter_linear[1] = 0;

    field {
        sw = rw; hw = r;
        desc = "Bits 2:1: addressModeU (VkSamplerAddressMode) -- 0 = REPEAT,
                1 = MIRRORED_REPEAT, 2 = CLAMP_TO_EDGE, 3 = CLAMP_TO_BORDER.
                Reset 2 (CLAMP_TO_EDGE) is exactly what the hardware did
                before this field existed. MIRROR_CLAMP_TO_EDGE needs an
                extension and is not implemented.

                NOTE: wrapping applies to a coordinate already converted to
                an unsigned texel index, so a NEGATIVE UV arrives as 0 and
                cannot wrap. Positive overflow wraps correctly. Fixing the
                negative case needs a signed coordinate conversion.";
    } addr_mode_u[2] = 2;

    field {
        sw = rw; hw = r;
        desc = "Bits 4:3: addressModeV, same encoding.";
    } addr_mode_v[2] = 2;

    field {
        sw = rw; hw = r;
        desc = "Bits 6:5: VkBorderColor for CLAMP_TO_BORDER -- 0 =
                TRANSPARENT_BLACK, 1 = OPAQUE_BLACK, 2 = OPAQUE_WHITE. The
                float and int variants of each collapse here; CUSTOM belongs
                to VK_EXT_custom_border_color and would need a colour
                register rather than an enum. Transparent and opaque black
                are the same value while the texture path stores no alpha.";
    } border_color[2] = 0;

    field { sw = rw; hw = na; } RSVD[25] = 0;
};

// --- Tile flusher Z-buffer base address (Step 25.3h) ---
reg flush_zb_base_reg_t {
    name = "Flush Z-buffer Base Address";
    desc = "20-bit DRAM byte address of the Z-buffer base.
            Written by firmware at startup; read by BorgTileFlusher on every
            tile flush.  nogen: decoded from the raw bus by Borg.scala.";

    field {
        sw = rw; hw = r;
        desc = "Bits 19:0: 20-bit DRAM byte address of Z-buffer base.";
    } zb_base[20] = 0;

    field {
        sw = rw; hw = na;
    } RSVD[12] = 0;
};

// --- Tile flusher framebuffer width (Step 25.3h) ---
reg flush_width_reg_t {
    name = "Flush Framebuffer Width";
    desc = "9-bit framebuffer width in pixels (max 512).
            Written by firmware at startup; used by BorgTileFlusher to compute
            per-pixel DRAM addresses.  nogen: decoded from the raw bus.";

    field {
        sw = rw; hw = r;
        desc = "Bits 8:0: Framebuffer width in pixels.";
    } fb_width[9] = 0;

    field {
        sw = rw; hw = na;
    } RSVD[23] = 0;
};



// --- Vertex Sequencer: descriptor DRAM base address (Step 29) ---
reg seq_desc_base_reg_t {
    name = "Sequencer Descriptor Base Address";
    desc = "20-bit DRAM byte address of the triangle descriptor (Option A layout:
            25 FP16 words = pos[3×3] | color[3×3] | uv[3×2] | flags).
            Write before triggering SEQ_TRIGGER.  nogen: decoded in Borg.scala.";

    field {
        sw = rw; hw = r;
        desc = "Bits 19:0: 20-bit DRAM byte address of triangle descriptor.";
    } base[20] = 0;

    field {
        sw = rw; hw = na;
    } RSVD[12] = 0;
};

// --- Vertex Sequencer: trigger (Step 29) ---
reg seq_trigger_reg_t {
    name = "Sequencer Trigger";
    desc = "Write bit 0 = 1 to start the vertex/triangle-setup sequencer.
            SEQ_DESC_BASE must be set before triggering.  Self-clearing.
            Poll STATUS.seq_busy for completion.  nogen: decoded in Borg.scala.";

    field {
        sw = w; hw = r;
        singlepulse;
        desc = "Bit 0: Start sequencer (self-clearing pulse).";
    } start[1] = 0;

    field {
        sw = w; hw = na;
    } RSVD[31] = 0;
};

// --- Vertex Sequencer: vertex shader DRAM address (Step 29.1) ---
reg seq_vert_addr_reg_t {
    name = "Sequencer Vertex Shader Address";
    desc = "20-bit DRAM byte address of the vertex shader binary.
            The sequencer DMA-loads this shader into IMEM before running
            vertex transformations.  nogen: decoded in Borg.scala.";

    field {
        sw = rw; hw = r;
        desc = "Bits 19:0: 20-bit DRAM byte address of vertex shader.";
    } addr[20] = 0;

    field {
        sw = rw; hw = na;
    } RSVD[12] = 0;
};

// --- Vertex Sequencer: vertex shader length (Step 29.1) ---
reg seq_vert_len_reg_t {
    name = "Sequencer Vertex Shader Length";
    desc = "Length of vertex shader binary in 32-bit DRAM words (1–56).
            The sequencer passes this to BorgDMA as the transfer length.
            nogen: decoded in Borg.scala.";

    field {
        sw = rw; hw = r;
        desc = "Bits 5:0: vertex shader length in 32-bit words.";
    } len[6] = 0;

    field {
        sw = rw; hw = na;
    } RSVD[26] = 0;
};

// --- Vertex Sequencer: setup shader DRAM address (Step 29.2) ---
reg seq_setup_addr_reg_t {
    name = "Sequencer Setup Shader Address";
    desc = "20-bit DRAM byte address of the triangle setup shader binary.
            The sequencer DMA-loads this shader into IMEM after vertex shading
            to compute edge vectors and inv_area.  nogen: decoded in Borg.scala.";

    field {
        sw = rw; hw = r;
        desc = "Bits 19:0: 20-bit DRAM byte address of setup shader.";
    } addr[20] = 0;

    field {
        sw = rw; hw = na;
    } RSVD[12] = 0;
};

// --- Vertex Sequencer: setup shader length (Step 29.2) ---
reg seq_setup_len_reg_t {
    name = "Sequencer Setup Shader Length";
    desc = "Length of setup shader binary in 32-bit DRAM words (1–56).
            nogen: decoded in Borg.scala.";

    field {
        sw = rw; hw = r;
        desc = "Bits 5:0: setup shader length in 32-bit words.";
    } len[6] = 0;

    field {
        sw = rw; hw = na;
    } RSVD[26] = 0;
};

// --- Vertex Sequencer: inv_width for edge normalization (Step 30.1c) ---
reg seq_inv_width_reg_t {
    name = "Sequencer Inverse Width";
    desc = "1/fb_width as a datapath float, written once during init.
            The sequencer writes this as u6 before running the setup shader,
            enabling hardware-level edge normalization.  nogen: decoded in Borg.scala.";

    field {
        sw = rw; hw = r;
        desc = "1/fb_width.";
    } value[32] = 0;
};

// --- Sequencer: triangle count (Step 31) ---
reg seq_tri_count_reg_t {
    name = "Sequencer Triangle Count";
    desc = "Number of triangle descriptors to process (1–16).
            The sequencer loops through triCount descriptors starting at
            SEQ_DESC_BASE with 128-byte stride.  nogen: decoded in Borg.scala.";

    field {
        sw = rw; hw = r;
        desc = "Bits 4:0: triangle count (1–16).";
    } count[5] = 0;

    field {
        sw = rw; hw = na;
    } RSVD[27] = 0;
};

// --- Sequencer: rast shader DRAM address (Step 31) ---
reg seq_rast_addr_reg_t {
    name = "Sequencer Rast Shader Address";
    desc = "20-bit DRAM byte address of the rasterizer shader binary.
            The sequencer DMA-loads this shader into IMEM after triangle setup
            to prepare for tile iteration.  nogen: decoded in Borg.scala.";

    field {
        sw = rw; hw = r;
        desc = "Bits 19:0: 20-bit DRAM byte address of rast shader.";
    } addr[20] = 0;

    field {
        sw = rw; hw = na;
    } RSVD[12] = 0;
};

// --- Sequencer: rast shader length (Step 31) ---
reg seq_rast_len_reg_t {
    name = "Sequencer Rast Shader Length";
    desc = "Length of rast shader binary in 32-bit DRAM words (1–56).
            nogen: decoded in Borg.scala.";

    field {
        sw = rw; hw = r;
        desc = "Bits 5:0: rast shader length in 32-bit words.";
    } len[6] = 0;

    field {
        sw = rw; hw = na;
    } RSVD[26] = 0;
};

// --- Sequencer: frag shader DRAM address (Step 31) ---
reg seq_frag_addr_reg_t {
    name = "Sequencer Frag Shader Address";
    desc = "20-bit DRAM byte address of the fragment shader binary.
            The sequencer DMA-loads this shader into IMEM after the rast shader
            to prepare for fragment shading.  nogen: decoded in Borg.scala.";

    field {
        sw = rw; hw = r;
        desc = "Bits 19:0: 20-bit DRAM byte address of frag shader.";
    } addr[20] = 0;

    field {
        sw = rw; hw = na;
    } RSVD[12] = 0;
};

// --- Sequencer: frag shader length (Step 31) ---
reg seq_frag_len_reg_t {
    name = "Sequencer Frag Shader Length";
    desc = "Length of frag shader binary in 32-bit DRAM words (1–56).
            nogen: decoded in Borg.scala.";

    field {
        sw = rw; hw = r;
        desc = "Bits 5:0: frag shader length in 32-bit words.";
    } len[6] = 0;

    field {
        sw = rw; hw = na;
    } RSVD[26] = 0;
};

// --- Sequencer: clear color low word (Step 31) ---
reg seq_clear_lo_reg_t {
    name = "Sequencer Clear Color Low";
    desc = "Packed {B[31:16], Z[15:0]} clear color for tile buffer pre-fill.
            The sequencer writes this to all 16 tile buffer entries before the
            first triangle on each tile.  nogen: decoded in Borg.scala.";

    field {
        sw = rw; hw = r;
        desc = "Bits 15:0: Z channel (FP16) of clear color.";
    } z[16] = 0;

    field {
        sw = rw; hw = r;
        desc = "Bits 31:16: B channel (FP16) of clear color.";
    } b[16] = 0;
};

// --- Sequencer: clear color high word (Step 31) ---
reg seq_clear_hi_reg_t {
    name = "Sequencer Clear Color High";
    desc = "Packed {R[31:16], G[15:0]} clear color for tile buffer pre-fill.
            nogen: decoded in Borg.scala.";

    field {
        sw = rw; hw = r;
        desc = "Bits 15:0: G channel (FP16) of clear color.";
    } g[16] = 0;

    field {
        sw = rw; hw = r;
        desc = "Bits 31:16: R channel (FP16) of clear color.";
    } red[16] = 0;
};

// --- Sequencer: Framebuffer base address (Step 31.4) ---
reg seq_fb_base_reg_t {
    name = "Sequencer Framebuffer Base Address";
    desc = "20-bit DRAM byte address of the framebuffer.
            Used by the sequencer to dynamically compute the flush base address
            during autonomous tile iteration.  nogen: decoded in Borg.scala.";

    field {
        sw = rw; hw = r;
        desc = "Bits 19:0: 20-bit DRAM byte address of framebuffer.";
    } addr[20] = 0;

    field {
        sw = rw; hw = na;
    } RSVD[12] = 0;
};

// --- Sequencer: Tiles per row (Step 31.4) ---
reg seq_tiles_per_row_reg_t {
    name = "Sequencer Tiles Per Row";
    desc = "Number of tiles in one row of the framebuffer (fb_width / 4).
            Used by the sequencer to compute the tile index.
            nogen: decoded in Borg.scala.";

    field {
        sw = rw; hw = r;
        desc = "Bits 9:0: tiles per row.";
    } count[10] = 0;

    field {
        sw = rw; hw = na;
    } RSVD[22] = 0;
};

// --- Sequencer: TBR bin list base address (Step 32.2) ---
reg seq_bin_base_reg_t {
    name = "Sequencer Bin List Base Address";
    desc = "20-bit DRAM byte address of the TBR bin list region.
            Each tile has a row of SEQ_MAX_TRI × 2-byte triangle indices.
            Written by firmware at frame start.  nogen: decoded in Borg.scala.";

    field {
        sw = rw; hw = r;
        desc = "Bits 19:0: 20-bit DRAM byte address of bin list base.";
    } addr[20] = 0;

    field {
        sw = rw; hw = na;
    } RSVD[12] = 0;
};

// --- Sequencer: TBR bin row bytes (Step 32.2) ---
reg seq_bin_row_bytes_reg_t {
    name = "Sequencer Bin Row Bytes";
    desc = "Bin list row size in bytes (= SEQ_MAX_TRI × TBR_BIN_ENTRY_SIZE).
            Each tile's bin list is this many bytes long in DRAM.
            Written by firmware at frame start.  nogen: decoded in Borg.scala.";

    field {
        sw = rw; hw = r;
        desc = "Bits 19:0: bin row size in bytes.";
    } size[20] = 0;

    field {
        sw = rw; hw = na;
    } RSVD[12] = 0;
};

// --- Sequencer: TBR setup store base address (Step 32.3) ---
reg seq_setup_base_reg_t {
    name = "Sequencer Setup Store Base Address";
    desc = "20-bit DRAM byte address of the TBR setup store region.
            Each triangle's 31 uniforms are stored at stride 128 bytes.
            Written by firmware at frame start.  nogen: decoded in Borg.scala.";

    field {
        sw = rw; hw = r;
        desc = "Bits 19:0: 20-bit DRAM byte address of setup store base.";
    } addr[20] = 0;

    field {
        sw = rw; hw = na;
    } RSVD[12] = 0;
};

// --- Performance counter (present-phase decomposition) ---
// 32-bit free-running cycle counter.  Counter logic lives in Borg.scala
// (wirePerf): reset at the rising edge of sequencer-busy, accumulated while its
// gate is high during the render, frozen when the sequencer goes idle — so SW
// reads the previous frame's exact cycle breakdown.  sw=r/hw=w exposes the
// Borg-side counter value to MMIO read, mirroring the status register.
reg perf_counter_reg_t {
    name = "Performance Counter";
    desc = "32-bit GPU cycle counter for present-phase decomposition.";

    field {
        sw = r; hw = w;
        desc = "32-bit cycle count (gate-dependent, per sequencer run).";
    } value[32] = 0;
};

// --- 16-bit FP register (stored in 32-bit word, upper bits ignored on write) ---
reg gpr_reg_t {
    name = "General Purpose Register";
    desc = "Shader register, one datapath float (FP32 in every current
            configuration; an FP16 build uses the low 16 bits and reads
            them back zero-extended).  32 entries: r0–r31.";

    field {
        sw = rw; hw = rw;
        desc = "Register value.";
    } value[32] = 0;
};

// --- 32-bit instruction memory word ---
reg imem_reg_t {
    name = "Instruction Memory";
    desc = "32-bit RISC-V instruction word.  72 slots (0–71).  Write-only from
            MMIO; the FPU fetches instructions from here during execution.";

    field {
        sw = w; hw = r;
        desc = "32-bit instruction (RISC-V R-type or R4-type encoding).";
    } instruction[32] = 0;
};

// --- 16-bit uniform buffer entry ---
reg uniform_reg_t {
    name = "Uniform Buffer Entry";
    desc = "Uniform value, one datapath float.  32 entries visible via MMIO (one page);
            CONTROL.uniform_write_page selects which hardware page (0 or 1)
            these writes target.  The GPU reads the page selected by the
            Command FIFO entry's uniformPage field.";

    field {
        sw = w; hw = r;
        desc = "Uniform value.";
    } value[32] = 0;
};


// --- Compute dispatch (BorgConfig.computeEnabled) ---
reg compute_ctrl_reg_t {
    name = "Compute Dispatch Control / Status";
    desc = "Write bit 0 = 1 to start a dispatch of COMPUTE_GROUPS workgroups,
            each running COMPUTE_LOCAL.count invocations of the shader at
            COMPUTE_PC. Load IMEM, LS_BASE and any uniforms first; the
            sequencer overwrites uniforms u29/u30/u31 of page 0 with the
            workgroup ID (x/y/z, raw integers) before each workgroup.
            Reading returns bit 0 = done (sticky, cleared by the next start),
            bit 1 = busy, bit 2 = compute hardware present.
            nogen: decoded in Borg.scala.";

    field {
        sw = w; hw = r;
        singlepulse;
        desc = "Bit 0: Start dispatch (self-clearing pulse).";
    } start[1] = 0;

    field {
        sw = w; hw = na;
    } RSVD[31] = 0;
};

reg compute_pc_reg_t {
    name = "Compute Shader Start PC";
    desc = "IMEM word index of the compute shader's first instruction.";

    field {
        sw = w; hw = r;
        desc = "Bits 5:0: start PC.";
    } pc[6] = 0;

    field {
        sw = w; hw = na;
    } RSVD[26] = 0;
};

reg compute_groups_xy_reg_t {
    name = "Compute Workgroup Count X/Y";
    desc = "vkCmdDispatch groupCountX/Y. A zero count in any dimension
            dispatches nothing and completes immediately.";

    field { sw = w; hw = r; desc = "Bits 15:0: groupCountX."; }  x[16] = 0;
    field { sw = w; hw = r; desc = "Bits 31:16: groupCountY."; } y[16] = 0;
};

reg compute_groups_z_reg_t {
    name = "Compute Workgroup Count Z";
    desc = "vkCmdDispatch groupCountZ.";

    field { sw = w; hw = r; desc = "Bits 15:0: groupCountZ."; } z[16] = 0;
    field { sw = w; hw = na; } RSVD[16] = 0;
};

reg compute_local_reg_t {
    name = "Compute Workgroup Size";
    desc = "The shader's LocalSize. count must equal x*y*z (the driver
            computes it; the hardware has no multiplier for it) and be at most
            128, Vulkan's minimum maxComputeWorkGroupInvocations. Each lane
            reads its invocation's IDs as raw integers: r30 =
            LocalInvocationIndex, r31 = LocalInvocationID packed as
            x | y << 10 | z << 20.";

    field { sw = w; hw = r; desc = "Bits 7:0: local size x."; }        x[8] = 0;
    field { sw = w; hw = r; desc = "Bits 15:8: local size y."; }       y[8] = 0;
    field { sw = w; hw = r; desc = "Bits 23:16: invocation count."; }  count[8] = 0;
    field { sw = w; hw = na; } RSVD[8] = 0;
};


// ============================================================================
// Address map
// ============================================================================

addrmap borg_gpu {
    name = "Borg GPU";
    desc = "Borg minimal FP16 shading processor — SystemRDL 2.0 register map.
            1024-byte address space (byte 0x000–0x3FF), 32-bit aligned.
            Base address is USER_BASE + USER_PERI_BORG × 1024 = 0x08000C00.";

    default hw = r;
    default sw = rw;

    // ---- Register File: 0x000 – 0x07C (32 entries × 4 bytes) ----
    gpr_reg_t gpr[32] @ 0x000 += 0x4;

    // ---- Instruction Memory: 0x080 – 0x19C (72 entries × 4 bytes) ----
    imem_reg_t imem[72] @ 0x080 += 0x4;

    // ---- Pixel Iterator Position / Advance: 0x1A4 ----
    iter_reg_t iter @ 0x1A4;

    // ---- Control (write only): 0x1A8 ----
    control_reg_t control;

    // ---- Status (read only): 0x1AC ----
    status_reg_t status;

    // ---- Uniform Buffer (1 page × 32 entries): 0x1B0 – 0x22C ----
    uniform_reg_t uniform[32] += 0x4;

    // ---- Tile Buffer Control: 0x230 ----
    tile_ctrl_reg_t tile_ctrl;

    // ---- Tile Buffer RG Read / Write Trigger: 0x234 ----
    tile_rg_reg_t tile_rg;

    // ---- Tile Buffer BZ Read / Shadow Latch: 0x238 ----
    tile_bz_reg_t tile_bz;

    // ---- Command FIFO Enqueue: 0x23C ----
    cmd_enqueue_reg_t cmd_enqueue;

    // tex_uv removed (no hw ports; firmware never writes it)

    // ---- Texture Address (HW-computed): 0x240 ----
    tex_addr_reg_t tex_addr;

    // ---- Texture Configuration: 0x244 ----
    tex_config_reg_t tex_config;

    // ---- Fragment Shader Start PC: 0x248 ----
    frag_pc_reg_t frag_pc;

    // ---- DMA DRAM Base Address: 0x210 — nogen on FPGA (hasDMA=false) ----
    dma_dram_reg_t dma_dram;
    dma_dram->nogen = true;

    // ---- DMA Configuration + Trigger: 0x214 — nogen on FPGA (hasDMA=false) ----
    dma_config_reg_t dma_config;
    dma_config->nogen = true;

    // ---- Flush Framebuffer Base Address: 0x218 — nogen (decoded in Borg.scala) ----
    flush_fb_base_reg_t flush_fb_base;
    flush_fb_base->nogen = true;

    // ---- Flush Z-buffer Base Address: 0x258 — nogen (decoded in Borg.scala) ----
    flush_zb_base_reg_t flush_zb_base;
    flush_zb_base->nogen = true;

    // ---- Flush Framebuffer Width: 0x25C — nogen (decoded in Borg.scala) ----
    flush_width_reg_t flush_width;
    flush_width->nogen = true;

    // ---- Sequencer Descriptor Base Address: 0x220 — nogen (decoded in Borg.scala) ----
    seq_desc_base_reg_t seq_desc_base;
    seq_desc_base->nogen = true;

    // ---- Sequencer Trigger: 0x224 — nogen (decoded in Borg.scala) ----
    seq_trigger_reg_t seq_trigger;
    seq_trigger->nogen = true;

    // ---- Sequencer Vertex Shader Address: 0x228 — nogen (Step 29.1) ----
    seq_vert_addr_reg_t seq_vert_addr;
    seq_vert_addr->nogen = true;

    // ---- Sequencer Vertex Shader Length: 0x22C — nogen (Step 29.1) ----
    seq_vert_len_reg_t seq_vert_len;
    seq_vert_len->nogen = true;

    // ---- Sequencer Setup Shader Address: 0x230 — nogen (Step 29.2) ----
    seq_setup_addr_reg_t seq_setup_addr;
    seq_setup_addr->nogen = true;

    // ---- Sequencer Setup Shader Length: 0x234 — nogen (Step 29.2) ----
    seq_setup_len_reg_t seq_setup_len;
    seq_setup_len->nogen = true;

    // ---- Sequencer Inverse Width: 0x238 — nogen (Step 30.1c) ----
    seq_inv_width_reg_t seq_inv_width;
    seq_inv_width->nogen = true;

    // ---- Sequencer Triangle Count: 0x23C — nogen (Step 31) ----
    seq_tri_count_reg_t seq_tri_count;
    seq_tri_count->nogen = true;

    // ---- Sequencer Rast Shader Address: 0x240 — nogen (Step 31) ----
    seq_rast_addr_reg_t seq_rast_addr;
    seq_rast_addr->nogen = true;

    // ---- Sequencer Rast Shader Length: 0x244 — nogen (Step 31) ----
    seq_rast_len_reg_t seq_rast_len;
    seq_rast_len->nogen = true;

    // ---- Sequencer Frag Shader Address: 0x248 — nogen (Step 31) ----
    seq_frag_addr_reg_t seq_frag_addr;
    seq_frag_addr->nogen = true;

    // ---- Sequencer Frag Shader Length: 0x24C — nogen (Step 31) ----
    seq_frag_len_reg_t seq_frag_len;
    seq_frag_len->nogen = true;

    // ---- Sequencer Clear Color Low: 0x250 — nogen (Step 31) ----
    seq_clear_lo_reg_t seq_clear_lo;
    seq_clear_lo->nogen = true;

    // ---- Sequencer Clear Color High: 0x254 — nogen (Step 31) ----
    seq_clear_hi_reg_t seq_clear_hi;
    seq_clear_hi->nogen = true;

    // ---- Sequencer Framebuffer Base Address: 0x258 — nogen (Step 31.4) ----
    seq_fb_base_reg_t seq_fb_base;
    seq_fb_base->nogen = true;

    // ---- Sequencer Tiles Per Row: 0x25C — nogen (Step 31.4) ----
    seq_tiles_per_row_reg_t seq_tiles_per_row;
    seq_tiles_per_row->nogen = true;

    // ---- Sequencer Bin List Base: 0x260 — nogen (Step 32.2) ----
    seq_bin_base_reg_t seq_bin_base;
    seq_bin_base->nogen = true;

    // ---- Sequencer Bin Row Bytes: 0x264 — nogen (Step 32.2) ----
    seq_bin_row_bytes_reg_t seq_bin_row_bytes;
    seq_bin_row_bytes->nogen = true;

    // ---- Sequencer Setup Store Base: 0x268 — nogen (Step 32.3) ----
    seq_setup_base_reg_t seq_setup_base;
    seq_setup_base->nogen = true;

    // ---- Depth test configuration — fully generated (hw=r, Borg reads
    //      io.hw.depth_cfg_compare_op / _write_en). Reset values reproduce
    //      the historical hardcoded LESS + always-write behaviour. ----
    depth_cfg_reg_t depth_cfg;

    // ---- Blend configuration — fully generated (hw=r, Borg reads
    //      io.hw.blend_cfg_* / blend_const_*). Reset 0 = blending disabled,
    //      i.e. the historical unconditional overwrite. ----
    blend_cfg_reg_t blend_cfg;
    blend_const_reg_t blend_const;

    // ---- Stencil configuration — fully generated (hw=r). Reset 0 = stencil
    //      disabled, i.e. the historical no-stencil behaviour. ----
    stencil_cfg_reg_t stencil_cfg;
    stencil_face_reg_t stencil_front;
    stencil_face_reg_t stencil_back;
    plane_clear_reg_t plane_clear;

    // ---- Face culling — fully generated (hw=r). Reset = cull back faces,
    //      the historical hardcoded behaviour. ----
    cull_cfg_reg_t cull_cfg;

    // ---- Scissor rectangle — fully generated (hw=r). Reset = disabled,
    //      i.e. every fragment passes. ----
    scissor_x_reg_t scissor_x;
    scissor_y_reg_t scissor_y;

    // ---- Load/store base — fully generated (hw=r). Reset 0. ----
    ls_base_reg_t ls_base;

    // ---- Sampler configuration — fully generated (hw=r). Reset = NEAREST. ----
    sampler_cfg_reg_t sampler_cfg;

    // ---- Performance counters: present-phase decomposition ----
    // Fully generated (hw=w → Borg drives io.hw.perf_*_value, SW reads).
    perf_counter_reg_t perf_total;   // 0x2AC: sequencer-active cycles (present total)
    perf_counter_reg_t perf_frag;    // 0x2B0: shader core running (vert+setup+frag)
    perf_counter_reg_t perf_flush;   // 0x2B4: tile flusher active (SDRAM writes)
    perf_counter_reg_t perf_stall;   // 0x2B8: gpuMem.req && !ready (SDRAM stall)
    perf_counter_reg_t perf_dma;     // 0x2BC: DMA active (bin/descriptor reads)

    // ---- Compute dispatch -- all nogen, decoded in Borg.scala only when
    //      BorgConfig.computeEnabled, so a build without compute (Wafer)
    //      carries no storage for them. ----
    compute_ctrl_reg_t compute_ctrl;
    compute_ctrl->nogen = true;
    compute_pc_reg_t compute_pc;
    compute_pc->nogen = true;
    compute_groups_xy_reg_t compute_groups_xy;
    compute_groups_xy->nogen = true;
    compute_groups_z_reg_t compute_groups_z;
    compute_groups_z->nogen = true;
    compute_local_reg_t compute_local;
    compute_local->nogen = true;

    // ---- Multi-texture binding: 4 base-address slots, FTEX rs3-selected ----
    tex_base_addr_reg_t tex_base_addr0;
    tex_base_addr_reg_t tex_base_addr1;
    tex_base_addr_reg_t tex_base_addr2;
    tex_base_addr_reg_t tex_base_addr3;

    // ---- Colour attachment format (RGB565 / RGBA8 / BGRA8) ----
    flush_format_reg_t flush_format;

    // ---- Shader program image for the instruction cache ----
    code_base_reg_t code_base;
    code_base->nogen = true;

    // ---- Occlusion queries ----
    occ_ctrl_reg_t occ_ctrl;
    occ_ctrl->nogen = true;
    occ_tri_range_reg_t occ_tri_range;
    occ_tri_range->nogen = true;
    occ_count_reg_t occ_count;
    occ_count->nogen = true;
};
